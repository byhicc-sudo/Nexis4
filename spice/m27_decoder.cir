* M27: behavioral four-level voltage threshold decoder (NOT transistor-level)
* 0=0V, 1=1.1V, A=2.2V, B=3.3V
* Three ideal comparator decisions; no propagation delay or power model.
VIN in 0 PWL(0n 0 5n 0 5.01n 1.1 15n 1.1 15.01n 2.2 25n 2.2 25.01n 3.3 40n 3.3)
BTH1 th1 0 V=3.3*(V(in)>0.55)
BTH2 th2 0 V=3.3*(V(in)>1.65)
BTH3 th3 0 V=3.3*(V(in)>2.75)
.tran 0.05n 40n
.control
set noaskquit
run
meas tran l0t1 FIND v(th1) AT=4n
meas tran l0t2 FIND v(th2) AT=4n
meas tran l0t3 FIND v(th3) AT=4n
meas tran l1t1 FIND v(th1) AT=10n
meas tran l1t2 FIND v(th2) AT=10n
meas tran l1t3 FIND v(th3) AT=10n
meas tran l2t1 FIND v(th1) AT=20n
meas tran l2t2 FIND v(th2) AT=20n
meas tran l2t3 FIND v(th3) AT=20n
meas tran l3t1 FIND v(th1) AT=30n
meas tran l3t2 FIND v(th2) AT=30n
meas tran l3t3 FIND v(th3) AT=30n
quit
.endc
.end
