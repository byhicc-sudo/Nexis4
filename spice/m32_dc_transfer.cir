* M32: DC voltage transfer of three transistor threshold sensors
* Simplified NMOS LEVEL=1; NOT production PDK or complete quaternary logic.
VDD vdd 0 3.3
VIN in 0 0
R1 vdd out1 10k
R2 vdd out2 10k
R3 vdd out3 10k
M1 out1 in 0 0 NTH1 W=10u L=1u
M2 out2 in 0 0 NTH2 W=10u L=1u
M3 out3 in 0 0 NTH3 W=10u L=1u
.model NTH1 NMOS (LEVEL=1 VTO=0.55 KP=0.001 LAMBDA=0.02)
.model NTH2 NMOS (LEVEL=1 VTO=1.65 KP=0.001 LAMBDA=0.02)
.model NTH3 NMOS (LEVEL=1 VTO=2.75 KP=0.001 LAMBDA=0.02)
.dc VIN 0 3.3 0.01
.control
set noaskquit
run
meas dc a0 FIND v(out1) AT=0
meas dc b0 FIND v(out2) AT=0
meas dc c0 FIND v(out3) AT=0
meas dc a1 FIND v(out1) AT=1.1
meas dc b1 FIND v(out2) AT=1.1
meas dc c1 FIND v(out3) AT=1.1
meas dc a2 FIND v(out1) AT=2.2
meas dc b2 FIND v(out2) AT=2.2
meas dc c2 FIND v(out3) AT=2.2
meas dc a3 FIND v(out1) AT=3.3
meas dc b3 FIND v(out2) AT=3.3
meas dc c3 FIND v(out3) AT=3.3
quit
.endc
.end
